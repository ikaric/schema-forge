Diode Clipping Overdrive Stage
* A hot guitar pickup signal (0.7 V peak, 1 kHz) driven into a symmetric soft
* clipper: a series resistor into anti-parallel diodes clamps the signal (the
* "overdrive"), then a coupling capacitor + load set the high-pass tone corner.
*
* Nets:  in -> R1 -> clip (clamped by D1/D2) -> C2 -> out -> RL -> gnd
V1   in   0    DC 0 AC 1 SIN(0 0.7 1k)
R1   in   clip 2.2k
D1   clip 0    DMOD
D2   0    clip DMOD
C2   clip out  22n
RL   out  0    100k
.model DMOD D(Is=2.52n Rs=0.568 N=1.752)
.ac   dec 50 10 100k
.tran 20u 10m 0 20u
.four 1000 v(clip)
.meas tran vout_pp  PP   v(clip)
.meas tran vout_max MAX  v(clip)
.meas ac   gain_db  MAX  vdb(out)
.meas ac   f_corner WHEN vdb(out)=-3 RISE=1
.end
